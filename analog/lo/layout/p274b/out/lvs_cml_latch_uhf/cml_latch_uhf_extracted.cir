* Extracted by KLayout with SG13G2 LVS runset on : 20/11/2026 12:29

.SUBCKT cml_latch_uhf ckn ckp dn dp nb_lo qn|qp vdd
M$1 \$1 \$1 \$1 \$1 sg13_lv_nmos L=0.13u W=16.5u AS=5.61p AD=5.61p PS=38.44u
+ PD=38.44u rfmode=0
M$2 \$6 nb_lo \$1 \$1 sg13_lv_nmos L=0.13u W=15u AS=3.3p AD=3.3p PS=20.2u
+ PD=20.2u rfmode=0
M$9 \$1 ckp \$20 \$1 sg13_lv_nmos L=0.13u W=7.5u AS=1.65p AD=1.65p PS=11.2u
+ PD=11.2u rfmode=0
M$14 \$21 ckn \$20 \$1 sg13_lv_nmos L=0.13u W=7.5u AS=1.65p AD=1.65p PS=11.2u
+ PD=11.2u rfmode=0
M$21 qn|qp dp \$42 \$1 sg13_lv_nmos L=0.13u W=7.5u AS=1.65p AD=1.65p PS=11.2u
+ PD=11.2u rfmode=0
M$26 qn|qp dn \$42 \$1 sg13_lv_nmos L=0.13u W=7.5u AS=1.65p AD=1.65p PS=11.2u
+ PD=11.2u rfmode=0
M$33 \$43 qn|qp qn|qp \$1 sg13_lv_nmos L=0.13u W=22.5u AS=4.95p AD=4.95p
+ PS=31.4u PD=31.4u rfmode=0
R$44 qn|qp vdd \$1 rppd w=2u l=5.334u ps=0u b=0 m=2
.ENDS cml_latch_uhf

* P2.7.4b lo_inv_2_4 CMOS inv [SCH]
.subckt lo_inv_2_4 a y vcv gnd
Mxp y a vcv vcv sg13_lv_pmos w=4u l=0.13u
Mxn y a gnd gnd sg13_lv_nmos w=2u l=0.13u
.ends

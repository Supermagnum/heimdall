* P2.7.4b lo_inv_05_1 CMOS inv [SCH]
.subckt lo_inv_05_1 a y vcv gnd
Mxp y a vcv vcv sg13_lv_pmos w=1u l=0.13u
Mxn y a gnd gnd sg13_lv_nmos w=0.5u l=0.13u
.ends

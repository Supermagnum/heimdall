* Extracted by KLayout with SG13G2 LVS runset on : 21/11/2026 11:51

.SUBCKT cml_conv dn dp gnd|vcv y
M$1 gnd|vcv gnd|vcv gnd|vcv gnd|vcv sg13_lv_nmos L=0.13u W=7u AS=2.38p AD=2.38p
+ PS=17.4u PD=17.4u rfmode=0
M$4 \$26 gnd|vcv gnd|vcv gnd|vcv sg13_lv_nmos L=0.13u W=3u AS=1.02p AD=1.02p
+ PS=6.68u PD=6.68u rfmode=0
M$5 y \$26 gnd|vcv gnd|vcv sg13_lv_nmos L=0.13u W=9u AS=3.06p AD=3.06p
+ PS=19.36u PD=19.36u rfmode=0
M$9 gnd|vcv gnd|vcv gnd|vcv gnd|vcv sg13_lv_pmos L=0.13u W=14u AS=4.76p
+ AD=4.76p PS=31.4u PD=31.4u rfmode=0
M$12 \$26 gnd|vcv gnd|vcv gnd|vcv sg13_lv_pmos L=0.13u W=6u AS=2.04p AD=2.04p
+ PS=12.68u PD=12.68u rfmode=0
M$13 y \$26 gnd|vcv gnd|vcv sg13_lv_pmos L=0.13u W=18u AS=6.12p AD=6.12p
+ PS=37.36u PD=37.36u rfmode=0
R$17 gnd|vcv gnd|vcv gnd|vcv rhigh w=0.5u l=17.58u ps=0u b=0 m=3
C$20 gnd|vcv dn cap_cmim w=5.71u l=5.71u A=32.6041p P=22.84u m=1
C$21 gnd|vcv gnd|vcv cap_cmim w=5.71u l=5.71u A=32.6041p P=22.84u m=1
C$22 gnd|vcv dp cap_cmim w=5.71u l=5.71u A=32.6041p P=22.84u m=1
.ENDS cml_conv

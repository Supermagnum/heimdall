* P2.7.4b cml_diff_pair_vhf — open-gate NMOS pair + end dummies
.subckt cml_diff_pair_vhf d1 d2 g1 g2 s gnd
Mm1 d1 g1 s gnd sg13_lv_nmos w=3u l=0.13u
Mm2 d2 g2 s gnd sg13_lv_nmos w=3u l=0.13u
Mdum gnd gnd gnd gnd sg13_lv_nmos w=1.2u l=0.13u
.ends

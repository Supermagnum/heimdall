* P2.7.4b cml_pair_loads_vhf flat [SCH]
.subckt cml_pair_loads_vhf d1 d2 g1 g2 s gnd vdd
Mm1 d1 g1 s gnd sg13_lv_nmos w=3u l=0.13u
Mm2 d2 g2 s gnd sg13_lv_nmos w=3u l=0.13u
Mdum gnd gnd gnd gnd sg13_lv_nmos w=1.2u l=0.13u
Rrlp vdd d1 gnd rppd w=2u l=13.335u ps=0u b=0 m=1
Rrln vdd d2 gnd rppd w=2u l=13.335u ps=0u b=0 m=1
.ends

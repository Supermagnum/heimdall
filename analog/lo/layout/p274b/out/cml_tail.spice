* P2.7.4b cml_tail MOSFET [SCH]
.subckt cml_tail drain nb_lo gnd
Mmt drain nb_lo gnd gnd sg13_lv_nmos w=15.0u l=0.13u
Mdum gnd gnd gnd gnd sg13_lv_nmos w=6.0u l=0.13u
.ends

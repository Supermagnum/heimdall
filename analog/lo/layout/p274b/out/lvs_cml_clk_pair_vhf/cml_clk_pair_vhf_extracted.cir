* Extracted by KLayout with SG13G2 LVS runset on : 20/11/2026 17:55

.SUBCKT cml_clk_pair_vhf d1 d2 g1 g2 gnd s
M$1 gnd gnd gnd gnd sg13_lv_nmos L=0.13u W=1.2u AS=0.408p AD=0.408p PS=3.76u
+ PD=3.76u rfmode=0
M$2 d1 g1 s gnd sg13_lv_nmos L=0.13u W=3u AS=0.66p AD=0.66p PS=5.8u PD=5.8u
+ rfmode=0
M$7 d2 g2 s gnd sg13_lv_nmos L=0.13u W=3u AS=0.66p AD=0.66p PS=5.8u PD=5.8u
+ rfmode=0
.ENDS cml_clk_pair_vhf

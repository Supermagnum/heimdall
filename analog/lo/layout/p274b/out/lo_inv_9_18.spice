* P2.7.4b lo_inv_9_18 = 2× lo_inv_45_9 parallel [SCH]
.subckt lo_inv_9_18 a y vcv gnd
Mxp y a vcv vcv sg13_lv_pmos w=9u l=0.13u m=2
Mxn y a gnd gnd sg13_lv_nmos w=4.5u l=0.13u m=2
.ends

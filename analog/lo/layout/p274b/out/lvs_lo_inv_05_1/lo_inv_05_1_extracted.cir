* Extracted by KLayout with SG13G2 LVS runset on : 21/11/2026 10:32

.SUBCKT lo_inv_05_1 a gnd vcv y
M$1 y a gnd gnd sg13_lv_nmos L=0.13u W=0.5u AS=0.17p AD=0.17p PS=1.68u PD=1.68u
+ rfmode=0
M$2 y a vcv vcv sg13_lv_pmos L=0.13u W=1u AS=0.34p AD=0.34p PS=2.68u PD=2.68u
+ rfmode=0
.ENDS lo_inv_05_1

* Extracted by KLayout with SG13G2 LVS runset on : 19/11/2026 19:35

.SUBCKT cml_pair_loads_tail d1 d2|gnd|nb_lo|s g1 g2 vdd
M$1 \$4 \$10 \$4 d2|gnd|nb_lo|s sg13_lv_nmos L=0.13u W=3u AS=1.02p AD=1.02p
+ PS=6.68u PD=6.68u rfmode=0
M$2 d2|gnd|nb_lo|s d2|gnd|nb_lo|s \$1 d2|gnd|nb_lo|s sg13_lv_nmos L=0.13u W=15u
+ AS=3.3p AD=3.3p PS=20.2u PD=20.2u rfmode=0
M$7 \$6 \$11 \$6 d2|gnd|nb_lo|s sg13_lv_nmos L=0.13u W=3u AS=1.02p AD=1.02p
+ PS=6.68u PD=6.68u rfmode=0
M$8 d2|gnd|nb_lo|s d2|gnd|nb_lo|s d2|gnd|nb_lo|s d2|gnd|nb_lo|s sg13_lv_nmos
+ L=0.13u W=3u AS=1.02p AD=1.02p PS=7.36u PD=7.36u rfmode=0
M$9 d1 g1 d2|gnd|nb_lo|s d2|gnd|nb_lo|s sg13_lv_nmos L=0.13u W=7.5u AS=1.65p
+ AD=1.65p PS=11.2u PD=11.2u rfmode=0
M$14 d2|gnd|nb_lo|s g2 d2|gnd|nb_lo|s d2|gnd|nb_lo|s sg13_lv_nmos L=0.13u
+ W=7.5u AS=1.65p AD=1.65p PS=11.2u PD=11.2u rfmode=0
R$20 d1 vdd d2|gnd|nb_lo|s rppd w=2u l=5.334u ps=0u b=0 m=1
R$21 d2|gnd|nb_lo|s vdd d2|gnd|nb_lo|s rppd w=2u l=5.334u ps=0u b=0 m=1
.ENDS cml_pair_loads_tail

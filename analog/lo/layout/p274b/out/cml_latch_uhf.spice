* P2.7.4b cml_latch_uhf flat LVS [SCH]
.subckt cml_latch_uhf dp dn ckp ckn qp qn nb_lo vdd gnd
Mma1 qn dp s1a gnd sg13_lv_nmos w=7.50u l=0.13u
Mma2 qp dn s1a gnd sg13_lv_nmos w=7.50u l=0.13u
Mma3 qn qp s2a gnd sg13_lv_nmos w=11.25u l=0.13u
Mma4 qp qn s2a gnd sg13_lv_nmos w=11.25u l=0.13u
Mma5 s1a ckp ta gnd sg13_lv_nmos w=7.50u l=0.13u
Mma6 s2a ckn ta gnd sg13_lv_nmos w=7.50u l=0.13u
Mmta ta nb_lo gnd gnd sg13_lv_nmos w=15.0u l=0.13u
Rrlp vdd qn gnd rppd w=2.0u l=5.334u ps=0u b=0 m=1
Rrln vdd qp gnd rppd w=2.0u l=5.334u ps=0u b=0 m=1
Mdum gnd gnd gnd gnd sg13_lv_nmos w=16.5u l=0.13u
.ends

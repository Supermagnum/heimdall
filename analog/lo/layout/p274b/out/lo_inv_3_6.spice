* P2.7.4b lo_inv_3_6 CMOS inv [SCH]
.subckt lo_inv_3_6 a y vcv gnd
Mxp y a vcv vcv sg13_lv_pmos w=6u l=0.13u
Mxn y a gnd gnd sg13_lv_nmos w=3u l=0.13u
.ends

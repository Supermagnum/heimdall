* Extracted by KLayout with SG13G2 LVS runset on : 19/11/2026 22:36

.SUBCKT cml_tail drain gnd nb_lo
M$1 gnd gnd gnd gnd sg13_lv_nmos L=0.13u W=6u AS=2.04p AD=2.04p PS=13.36u
+ PD=13.36u rfmode=0
M$2 drain nb_lo gnd gnd sg13_lv_nmos L=0.13u W=15u AS=3.3p AD=3.3p PS=20.2u
+ PD=20.2u rfmode=0
.ENDS cml_tail

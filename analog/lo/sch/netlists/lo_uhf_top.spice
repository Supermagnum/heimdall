* P2.7.4b lo_uhf_top hierarchical LVS [SCH]
* Generated from leaf cells; flat superseded.
* P2.7.4b lo_bias LVS reference [SCH]
.subckt lo_bias nbias en_lodiv nb_lo vdd gnd
Mxenb_p en_n en_lodiv vdd vdd sg13_lv_pmos w=1u l=0.13u
Mxenb_n en_n en_lodiv 0 0 sg13_lv_nmos w=0.5u l=0.13u
Mtgn nb_lo en_lodiv nbias 0 sg13_lv_nmos w=4u l=0.13u
Mtgp nb_lo en_n nbias vdd sg13_lv_pmos w=8u l=0.13u
Mmpd nb_lo en_n 0 0 sg13_lv_nmos w=2u l=0.13u
.ends

* P2.7.4b lo_buffer LVS reference [SCH]
.subckt lo_buffer tp tn ckp ckn vbuf gnd
ccp (tp x_bip) capacitor c=100f
rfp (x_bip x_bop) resistor r=50k
Mxb1pp x_bop x_bip vbuf vbuf sg13_lv_pmos w=4u l=0.13u
Mxb1pn x_bop x_bip 0 0 sg13_lv_nmos w=2u l=0.13u
ccmp (x_bop x_mip) capacitor c=50f
rfmp (x_mip x_bmp) resistor r=50k
Mxbmpp x_bmp x_mip vbuf vbuf sg13_lv_pmos w=6u l=0.13u
Mxbmpn x_bmp x_mip 0 0 sg13_lv_nmos w=3u l=0.13u
Mxb2pp ckp x_bmp vbuf vbuf sg13_lv_pmos w=8.0u l=0.13u
Mxb2pn ckp x_bmp 0 0 sg13_lv_nmos w=4.0u l=0.13u
ccn (tn x_bin) capacitor c=100f
rfn (x_bin x_bon) resistor r=50k
Mxb1np x_bon x_bin vbuf vbuf sg13_lv_pmos w=4u l=0.13u
Mxb1nn x_bon x_bin 0 0 sg13_lv_nmos w=2u l=0.13u
ccmn (x_bon x_min) capacitor c=50f
rfmn (x_min x_bmn) resistor r=50k
Mxbmnp x_bmn x_min vbuf vbuf sg13_lv_pmos w=6u l=0.13u
Mxbmnn x_bmn x_min 0 0 sg13_lv_nmos w=3u l=0.13u
Mxb2np ckn x_bmn vbuf vbuf sg13_lv_pmos w=8.0u l=0.13u
Mxb2nn ckn x_bmn 0 0 sg13_lv_nmos w=4.0u l=0.13u
Mxbxpp x_bon x_bop vbuf vbuf sg13_lv_pmos w=1u l=0.13u
Mxbxpn x_bon x_bop 0 0 sg13_lv_nmos w=0.5u l=0.13u
Mxbxnp x_bop x_bon vbuf vbuf sg13_lv_pmos w=1u l=0.13u
Mxbxnn x_bop x_bon 0 0 sg13_lv_nmos w=0.5u l=0.13u
Mxbopp ckn ckp vbuf vbuf sg13_lv_pmos w=2u l=0.13u
Mxbopn ckn ckp 0 0 sg13_lv_nmos w=1u l=0.13u
Mxbonp ckp ckn vbuf vbuf sg13_lv_pmos w=2u l=0.13u
Mxbonn ckp ckn 0 0 sg13_lv_nmos w=1u l=0.13u
.ends

* P2.7.4b lo_converter LVS reference [SCH]
.subckt lo_converter dp dn y vcv gnd
ccap (dp x_cip) capacitor c=50f
rcap (x_cip x_o2p) resistor r=50k
Mxcapp x_o2p x_cip vcv vcv sg13_lv_pmos w=4u l=0.13u
Mxcapn x_o2p x_cip 0 0 sg13_lv_nmos w=2u l=0.13u
ccan (dn x_cin) capacitor c=50f
rcan (x_cin x_o2n) resistor r=50k
Mxcanp x_o2n x_cin vcv vcv sg13_lv_pmos w=4u l=0.13u
Mxcann x_o2n x_cin 0 0 sg13_lv_nmos w=2u l=0.13u
Mxcxpp x_o2n x_o2p vcv vcv sg13_lv_pmos w=1u l=0.13u
Mxcxpn x_o2n x_o2p 0 0 sg13_lv_nmos w=0.5u l=0.13u
Mxcxnp x_o2p x_o2n vcv vcv sg13_lv_pmos w=1u l=0.13u
Mxcxnn x_o2p x_o2n 0 0 sg13_lv_nmos w=0.5u l=0.13u
ccb (x_o2p x_cbi) capacitor c=50f
rcb (x_cbi x_cy) resistor r=50k
Mxcbp x_cy x_cbi vcv vcv sg13_lv_pmos w=4u l=0.13u
Mxcbn x_cy x_cbi 0 0 sg13_lv_nmos w=2u l=0.13u
Mxcv3p x_cz x_cy vcv vcv sg13_lv_pmos w=6.0u l=0.13u
Mxcv3n x_cz x_cy 0 0 sg13_lv_nmos w=3.0u l=0.13u
Mxcv4p y x_cz vcv vcv sg13_lv_pmos w=9.0u l=0.13u m=2
Mxcv4n y x_cz 0 0 sg13_lv_nmos w=4.5u l=0.13u m=2
.ends

* P2.7.4b cml_dff_uhf LVS reference [SCH]
.subckt cml_dff_uhf dp dn ckp ckn qp qn nb_lo vdv gnd
Rrlamp vdv map gnd rppd w=2.0u l=5.334u ps=0.18u b=0 m=1
Rrlamn vdv man gnd rppd w=2.0u l=5.334u ps=0.18u b=0 m=1
Mmam1 man dp s1am 0 sg13_lv_nmos w=7.50u l=0.13u
Mmam2 map dn s1am 0 sg13_lv_nmos w=7.50u l=0.13u
Mmam3 man map s2am 0 sg13_lv_nmos w=11.25u l=0.13u
Mmam4 map man s2am 0 sg13_lv_nmos w=11.25u l=0.13u
Mmam5 s1am ckp tam 0 sg13_lv_nmos w=7.50u l=0.13u
Mmam6 s2am ckn tam 0 sg13_lv_nmos w=7.50u l=0.13u
Mmtam tam nb_lo 0 0 sg13_lv_nmos w=15u l=0.13u

Rrlasp vdv qp gnd rppd w=2.0u l=5.334u ps=0.18u b=0 m=1
Rrlasn vdv qn gnd rppd w=2.0u l=5.334u ps=0.18u b=0 m=1
Mmas1 qn map s1as 0 sg13_lv_nmos w=7.50u l=0.13u
Mmas2 qp man s1as 0 sg13_lv_nmos w=7.50u l=0.13u
Mmas3 qn qp s2as 0 sg13_lv_nmos w=11.25u l=0.13u
Mmas4 qp qn s2as 0 sg13_lv_nmos w=11.25u l=0.13u
Mmas5 s1as ckn tas 0 sg13_lv_nmos w=7.50u l=0.13u
Mmas6 s2as ckp tas 0 sg13_lv_nmos w=7.50u l=0.13u
Mmtas tas nb_lo 0 0 sg13_lv_nmos w=15u l=0.13u

.ends

* P2.7.4b lo_johnson_uhf LVS reference [SCH]
.subckt lo_johnson_uhf x_clk x_p0 x_p1 x_p2 x_p3 vdg gnd
Mxf1p1 x_f1_x1 x_q2 vdg vdg sg13_lv_pmos w=2u l=0.13u
Mxf1p2 x_f1_a x_clk x_f1_x1 vdg sg13_lv_pmos w=2u l=0.13u
Mxf1n1 x_f1_a x_q2 0 0 sg13_lv_nmos w=1u l=0.13u
Mxf1p3 x_f1_b x_clk vdg vdg sg13_lv_pmos w=2u l=0.13u
Mxf1n2 x_f1_b x_f1_a x_f1_x2 0 sg13_lv_nmos w=1u l=0.13u
Mxf1n3 x_f1_x2 x_clk 0 0 sg13_lv_nmos w=1u l=0.13u
Mxf1p4 x_q1 x_f1_b vdg vdg sg13_lv_pmos w=2u l=0.13u
Mxf1n4 x_q1 x_clk x_f1_x3 0 sg13_lv_nmos w=1u l=0.13u
Mxf1n5 x_f1_x3 x_f1_b 0 0 sg13_lv_nmos w=1u l=0.13u

Mxi1p x_q1b x_q1 vdg vdg sg13_lv_pmos w=1.0u l=0.13u
Mxi1n x_q1b x_q1 0 0 sg13_lv_nmos w=0.5u l=0.13u
Mxf2p1 x_f2_x1 x_q1b vdg vdg sg13_lv_pmos w=2u l=0.13u
Mxf2p2 x_f2_a x_clk x_f2_x1 vdg sg13_lv_pmos w=2u l=0.13u
Mxf2n1 x_f2_a x_q1b 0 0 sg13_lv_nmos w=1u l=0.13u
Mxf2p3 x_f2_b x_clk vdg vdg sg13_lv_pmos w=2u l=0.13u
Mxf2n2 x_f2_b x_f2_a x_f2_x2 0 sg13_lv_nmos w=1u l=0.13u
Mxf2n3 x_f2_x2 x_clk 0 0 sg13_lv_nmos w=1u l=0.13u
Mxf2p4 x_q2 x_f2_b vdg vdg sg13_lv_pmos w=2u l=0.13u
Mxf2n4 x_q2 x_clk x_f2_x3 0 sg13_lv_nmos w=1u l=0.13u
Mxf2n5 x_f2_x3 x_f2_b 0 0 sg13_lv_nmos w=1u l=0.13u

Mxi2p x_q2b x_q2 vdg vdg sg13_lv_pmos w=1.0u l=0.13u
Mxi2n x_q2b x_q2 0 0 sg13_lv_nmos w=0.5u l=0.13u
Mxg0pa x_n0 x_q1 vdg vdg sg13_lv_pmos w=1u l=0.13u
Mxg0pb x_n0 x_q2b vdg vdg sg13_lv_pmos w=1u l=0.13u
Mxg0na x_n0 x_q1 x_g0m 0 sg13_lv_nmos w=1u l=0.13u
Mxg0nb x_g0m x_q2b 0 0 sg13_lv_nmos w=1u l=0.13u
Mxr0p1 x_r0_x1 x_n0 vdg vdg sg13_lv_pmos w=2u l=0.13u
Mxr0p2 x_r0_a x_clk x_r0_x1 vdg sg13_lv_pmos w=2u l=0.13u
Mxr0n1 x_r0_a x_n0 0 0 sg13_lv_nmos w=1u l=0.13u
Mxr0p3 x_r0_b x_clk vdg vdg sg13_lv_pmos w=2u l=0.13u
Mxr0n2 x_r0_b x_r0_a x_r0_x2 0 sg13_lv_nmos w=1u l=0.13u
Mxr0n3 x_r0_x2 x_clk 0 0 sg13_lv_nmos w=1u l=0.13u
Mxr0p4 x_p0 x_r0_b vdg vdg sg13_lv_pmos w=4u l=0.13u
Mxr0n4 x_p0 x_clk x_r0_x3 0 sg13_lv_nmos w=1u l=0.13u
Mxr0n5 x_r0_x3 x_r0_b 0 0 sg13_lv_nmos w=1u l=0.13u

cpl0 (x_p0 0) capacitor c=20f
Mxg1pa x_n1 x_q1 vdg vdg sg13_lv_pmos w=1u l=0.13u
Mxg1pb x_n1 x_q2 vdg vdg sg13_lv_pmos w=1u l=0.13u
Mxg1na x_n1 x_q1 x_g1m 0 sg13_lv_nmos w=1u l=0.13u
Mxg1nb x_g1m x_q2 0 0 sg13_lv_nmos w=1u l=0.13u
Mxr1p1 x_r1_x1 x_n1 vdg vdg sg13_lv_pmos w=2u l=0.13u
Mxr1p2 x_r1_a x_clk x_r1_x1 vdg sg13_lv_pmos w=2u l=0.13u
Mxr1n1 x_r1_a x_n1 0 0 sg13_lv_nmos w=1u l=0.13u
Mxr1p3 x_r1_b x_clk vdg vdg sg13_lv_pmos w=2u l=0.13u
Mxr1n2 x_r1_b x_r1_a x_r1_x2 0 sg13_lv_nmos w=1u l=0.13u
Mxr1n3 x_r1_x2 x_clk 0 0 sg13_lv_nmos w=1u l=0.13u
Mxr1p4 x_p1 x_r1_b vdg vdg sg13_lv_pmos w=4u l=0.13u
Mxr1n4 x_p1 x_clk x_r1_x3 0 sg13_lv_nmos w=1u l=0.13u
Mxr1n5 x_r1_x3 x_r1_b 0 0 sg13_lv_nmos w=1u l=0.13u

cpl1 (x_p1 0) capacitor c=20f
Mxg2pa x_n2 x_q1b vdg vdg sg13_lv_pmos w=1u l=0.13u
Mxg2pb x_n2 x_q2 vdg vdg sg13_lv_pmos w=1u l=0.13u
Mxg2na x_n2 x_q1b x_g2m 0 sg13_lv_nmos w=1u l=0.13u
Mxg2nb x_g2m x_q2 0 0 sg13_lv_nmos w=1u l=0.13u
Mxr2p1 x_r2_x1 x_n2 vdg vdg sg13_lv_pmos w=2u l=0.13u
Mxr2p2 x_r2_a x_clk x_r2_x1 vdg sg13_lv_pmos w=2u l=0.13u
Mxr2n1 x_r2_a x_n2 0 0 sg13_lv_nmos w=1u l=0.13u
Mxr2p3 x_r2_b x_clk vdg vdg sg13_lv_pmos w=2u l=0.13u
Mxr2n2 x_r2_b x_r2_a x_r2_x2 0 sg13_lv_nmos w=1u l=0.13u
Mxr2n3 x_r2_x2 x_clk 0 0 sg13_lv_nmos w=1u l=0.13u
Mxr2p4 x_p2 x_r2_b vdg vdg sg13_lv_pmos w=4u l=0.13u
Mxr2n4 x_p2 x_clk x_r2_x3 0 sg13_lv_nmos w=1u l=0.13u
Mxr2n5 x_r2_x3 x_r2_b 0 0 sg13_lv_nmos w=1u l=0.13u

cpl2 (x_p2 0) capacitor c=20f
Mxg3pa x_n3 x_q1b vdg vdg sg13_lv_pmos w=1u l=0.13u
Mxg3pb x_n3 x_q2b vdg vdg sg13_lv_pmos w=1u l=0.13u
Mxg3na x_n3 x_q1b x_g3m 0 sg13_lv_nmos w=1u l=0.13u
Mxg3nb x_g3m x_q2b 0 0 sg13_lv_nmos w=1u l=0.13u
Mxr3p1 x_r3_x1 x_n3 vdg vdg sg13_lv_pmos w=2u l=0.13u
Mxr3p2 x_r3_a x_clk x_r3_x1 vdg sg13_lv_pmos w=2u l=0.13u
Mxr3n1 x_r3_a x_n3 0 0 sg13_lv_nmos w=1u l=0.13u
Mxr3p3 x_r3_b x_clk vdg vdg sg13_lv_pmos w=2u l=0.13u
Mxr3n2 x_r3_b x_r3_a x_r3_x2 0 sg13_lv_nmos w=1u l=0.13u
Mxr3n3 x_r3_x2 x_clk 0 0 sg13_lv_nmos w=1u l=0.13u
Mxr3p4 x_p3 x_r3_b vdg vdg sg13_lv_pmos w=4u l=0.13u
Mxr3n4 x_p3 x_clk x_r3_x3 0 sg13_lv_nmos w=1u l=0.13u
Mxr3n5 x_r3_x3 x_r3_b 0 0 sg13_lv_nmos w=1u l=0.13u

cpl3 (x_p3 0) capacitor c=20f
Mxf1kq1p x_f1_kq x_q1 vdg vdg sg13_lv_pmos w=0.3u l=0.13u
Mxf1kq1n x_f1_kq x_q1 0 0 sg13_lv_nmos w=0.15u l=0.13u
Mxf1kq2p x_q1 x_f1_kq vdg vdg sg13_lv_pmos w=0.3u l=0.13u
Mxf1kq2n x_q1 x_f1_kq 0 0 sg13_lv_nmos w=0.15u l=0.13u
rkf11 (x_f1_a 0) resistor r=100Meg
rkf12 (x_f1_b 0) resistor r=100Meg
Mxf2kq1p x_f2_kq x_q2 vdg vdg sg13_lv_pmos w=0.3u l=0.13u
Mxf2kq1n x_f2_kq x_q2 0 0 sg13_lv_nmos w=0.15u l=0.13u
Mxf2kq2p x_q2 x_f2_kq vdg vdg sg13_lv_pmos w=0.3u l=0.13u
Mxf2kq2n x_q2 x_f2_kq 0 0 sg13_lv_nmos w=0.15u l=0.13u
rkf21 (x_f2_a 0) resistor r=100Meg
rkf22 (x_f2_b 0) resistor r=100Meg
Mxr0kq1p x_r0_kq x_p0 vdg vdg sg13_lv_pmos w=0.3u l=0.13u
Mxr0kq1n x_r0_kq x_p0 0 0 sg13_lv_nmos w=0.15u l=0.13u
Mxr0kq2p x_p0 x_r0_kq vdg vdg sg13_lv_pmos w=0.3u l=0.13u
Mxr0kq2n x_p0 x_r0_kq 0 0 sg13_lv_nmos w=0.15u l=0.13u
rkr01 (x_r0_a 0) resistor r=100Meg
rkr02 (x_r0_b 0) resistor r=100Meg
Mxr1kq1p x_r1_kq x_p1 vdg vdg sg13_lv_pmos w=0.3u l=0.13u
Mxr1kq1n x_r1_kq x_p1 0 0 sg13_lv_nmos w=0.15u l=0.13u
Mxr1kq2p x_p1 x_r1_kq vdg vdg sg13_lv_pmos w=0.3u l=0.13u
Mxr1kq2n x_p1 x_r1_kq 0 0 sg13_lv_nmos w=0.15u l=0.13u
rkr11 (x_r1_a 0) resistor r=100Meg
rkr12 (x_r1_b 0) resistor r=100Meg
Mxr2kq1p x_r2_kq x_p2 vdg vdg sg13_lv_pmos w=0.3u l=0.13u
Mxr2kq1n x_r2_kq x_p2 0 0 sg13_lv_nmos w=0.15u l=0.13u
Mxr2kq2p x_p2 x_r2_kq vdg vdg sg13_lv_pmos w=0.3u l=0.13u
Mxr2kq2n x_p2 x_r2_kq 0 0 sg13_lv_nmos w=0.15u l=0.13u
rkr21 (x_r2_a 0) resistor r=100Meg
rkr22 (x_r2_b 0) resistor r=100Meg
Mxr3kq1p x_r3_kq x_p3 vdg vdg sg13_lv_pmos w=0.3u l=0.13u
Mxr3kq1n x_r3_kq x_p3 0 0 sg13_lv_nmos w=0.15u l=0.13u
Mxr3kq2p x_p3 x_r3_kq vdg vdg sg13_lv_pmos w=0.3u l=0.13u
Mxr3kq2n x_p3 x_r3_kq 0 0 sg13_lv_nmos w=0.15u l=0.13u
rkr31 (x_r3_a 0) resistor r=100Meg
rkr32 (x_r3_b 0) resistor r=100Meg
.ends

.subckt lo_uhf_top tp tn nbias en_lodiv x_p0 x_p1 x_p2 x_p3 vbuf vdv vcv vdg vdd 0
Xbias nbias en_lodiv nb_lo vdd 0 lo_bias
Xbuf tp tn ckp ckn vbuf 0 lo_buffer
Xdiv qn qp ckp ckn qp qn nb_lo vdv 0 cml_dff_uhf
Xconv qp qn x_clk vcv 0 lo_converter
Xjohn x_clk x_p0 x_p1 x_p2 x_p3 vdg 0 lo_johnson_uhf
.ends

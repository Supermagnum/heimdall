* P2.7.4b cml_nor_vhf LVS reference [SCH]
.subckt cml_nor_vhf q1p q2p vref orp orn nb_lo vdd gnd
Rrgp vdd orp gnd rppd w=2.0u l=13.334u ps=0.18u b=0 m=1
Rrgn vdd orn gnd rppd w=2.0u l=13.334u ps=0.18u b=0 m=1
Mmga orn q1p tg 0 sg13_lv_nmos w=3.00u l=0.13u
Mmgb orn q2p tg 0 sg13_lv_nmos w=3.00u l=0.13u
Mmgr orp vref tg 0 sg13_lv_nmos w=3.00u l=0.13u
Mmtg tg nb_lo 0 0 sg13_lv_nmos w=6u l=0.13u
.ends

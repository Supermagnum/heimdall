* P2.7.4b lo_johnson_vhf LVS reference [SCH]
.subckt lo_johnson_vhf x_clk x_r1 x_r2 x_r3 x_r4 x_r1b x_r2b x_r3b x_r4b vdg gnd
Mxf1p1 x_f1_x1 x_q4 vdg vdg sg13_lv_pmos w=2u l=0.13u
Mxf1p2 x_f1_a x_clk x_f1_x1 vdg sg13_lv_pmos w=2u l=0.13u
Mxf1n1 x_f1_a x_q4 0 0 sg13_lv_nmos w=1u l=0.13u
Mxf1p3 x_f1_b x_clk vdg vdg sg13_lv_pmos w=2u l=0.13u
Mxf1n2 x_f1_b x_f1_a x_f1_x2 0 sg13_lv_nmos w=1u l=0.13u
Mxf1n3 x_f1_x2 x_clk 0 0 sg13_lv_nmos w=1u l=0.13u
Mxf1p4 x_q1 x_f1_b vdg vdg sg13_lv_pmos w=2u l=0.13u
Mxf1n4 x_q1 x_clk x_f1_x3 0 sg13_lv_nmos w=1u l=0.13u
Mxf1n5 x_f1_x3 x_f1_b 0 0 sg13_lv_nmos w=1u l=0.13u

Mxi2p x_d2 x_q1 vdg vdg sg13_lv_pmos w=1.0u l=0.13u
Mxi2n x_d2 x_q1 0 0 sg13_lv_nmos w=0.5u l=0.13u
Mxf2p1 x_f2_x1 x_d2 vdg vdg sg13_lv_pmos w=2u l=0.13u
Mxf2p2 x_f2_a x_clk x_f2_x1 vdg sg13_lv_pmos w=2u l=0.13u
Mxf2n1 x_f2_a x_d2 0 0 sg13_lv_nmos w=1u l=0.13u
Mxf2p3 x_f2_b x_clk vdg vdg sg13_lv_pmos w=2u l=0.13u
Mxf2n2 x_f2_b x_f2_a x_f2_x2 0 sg13_lv_nmos w=1u l=0.13u
Mxf2n3 x_f2_x2 x_clk 0 0 sg13_lv_nmos w=1u l=0.13u
Mxf2p4 x_q2 x_f2_b vdg vdg sg13_lv_pmos w=2u l=0.13u
Mxf2n4 x_q2 x_clk x_f2_x3 0 sg13_lv_nmos w=1u l=0.13u
Mxf2n5 x_f2_x3 x_f2_b 0 0 sg13_lv_nmos w=1u l=0.13u

Mxi3p x_d3 x_q2 vdg vdg sg13_lv_pmos w=1.0u l=0.13u
Mxi3n x_d3 x_q2 0 0 sg13_lv_nmos w=0.5u l=0.13u
Mxf3p1 x_f3_x1 x_d3 vdg vdg sg13_lv_pmos w=2u l=0.13u
Mxf3p2 x_f3_a x_clk x_f3_x1 vdg sg13_lv_pmos w=2u l=0.13u
Mxf3n1 x_f3_a x_d3 0 0 sg13_lv_nmos w=1u l=0.13u
Mxf3p3 x_f3_b x_clk vdg vdg sg13_lv_pmos w=2u l=0.13u
Mxf3n2 x_f3_b x_f3_a x_f3_x2 0 sg13_lv_nmos w=1u l=0.13u
Mxf3n3 x_f3_x2 x_clk 0 0 sg13_lv_nmos w=1u l=0.13u
Mxf3p4 x_q3 x_f3_b vdg vdg sg13_lv_pmos w=2u l=0.13u
Mxf3n4 x_q3 x_clk x_f3_x3 0 sg13_lv_nmos w=1u l=0.13u
Mxf3n5 x_f3_x3 x_f3_b 0 0 sg13_lv_nmos w=1u l=0.13u

Mxi4p x_d4 x_q3 vdg vdg sg13_lv_pmos w=1.0u l=0.13u
Mxi4n x_d4 x_q3 0 0 sg13_lv_nmos w=0.5u l=0.13u
Mxf4p1 x_f4_x1 x_d4 vdg vdg sg13_lv_pmos w=2u l=0.13u
Mxf4p2 x_f4_a x_clk x_f4_x1 vdg sg13_lv_pmos w=2u l=0.13u
Mxf4n1 x_f4_a x_d4 0 0 sg13_lv_nmos w=1u l=0.13u
Mxf4p3 x_f4_b x_clk vdg vdg sg13_lv_pmos w=2u l=0.13u
Mxf4n2 x_f4_b x_f4_a x_f4_x2 0 sg13_lv_nmos w=1u l=0.13u
Mxf4n3 x_f4_x2 x_clk 0 0 sg13_lv_nmos w=1u l=0.13u
Mxf4p4 x_q4 x_f4_b vdg vdg sg13_lv_pmos w=2u l=0.13u
Mxf4n4 x_q4 x_clk x_f4_x3 0 sg13_lv_nmos w=1u l=0.13u
Mxf4n5 x_f4_x3 x_f4_b 0 0 sg13_lv_nmos w=1u l=0.13u

Mxo1p x_q1b x_q1 vdg vdg sg13_lv_pmos w=1.0u l=0.13u
Mxo1n x_q1b x_q1 0 0 sg13_lv_nmos w=0.5u l=0.13u
Mxr1ap1 x_r1a_x1 x_q1b vdg vdg sg13_lv_pmos w=2u l=0.13u
Mxr1ap2 x_r1a_a x_clk x_r1a_x1 vdg sg13_lv_pmos w=2u l=0.13u
Mxr1an1 x_r1a_a x_q1b 0 0 sg13_lv_nmos w=1u l=0.13u
Mxr1ap3 x_r1a_b x_clk vdg vdg sg13_lv_pmos w=2u l=0.13u
Mxr1an2 x_r1a_b x_r1a_a x_r1a_x2 0 sg13_lv_nmos w=1u l=0.13u
Mxr1an3 x_r1a_x2 x_clk 0 0 sg13_lv_nmos w=1u l=0.13u
Mxr1ap4 x_r1 x_r1a_b vdg vdg sg13_lv_pmos w=2u l=0.13u
Mxr1an4 x_r1 x_clk x_r1a_x3 0 sg13_lv_nmos w=1u l=0.13u
Mxr1an5 x_r1a_x3 x_r1a_b 0 0 sg13_lv_nmos w=1u l=0.13u

Mxr1bp1 x_r1b_x1 x_q1 vdg vdg sg13_lv_pmos w=2u l=0.13u
Mxr1bp2 x_r1b_a x_clk x_r1b_x1 vdg sg13_lv_pmos w=2u l=0.13u
Mxr1bn1 x_r1b_a x_q1 0 0 sg13_lv_nmos w=1u l=0.13u
Mxr1bp3 x_r1b_b x_clk vdg vdg sg13_lv_pmos w=2u l=0.13u
Mxr1bn2 x_r1b_b x_r1b_a x_r1b_x2 0 sg13_lv_nmos w=1u l=0.13u
Mxr1bn3 x_r1b_x2 x_clk 0 0 sg13_lv_nmos w=1u l=0.13u
Mxr1bp4 x_r1b x_r1b_b vdg vdg sg13_lv_pmos w=2u l=0.13u
Mxr1bn4 x_r1b x_clk x_r1b_x3 0 sg13_lv_nmos w=1u l=0.13u
Mxr1bn5 x_r1b_x3 x_r1b_b 0 0 sg13_lv_nmos w=1u l=0.13u

cr1 (x_r1 0) capacitor c=10f
crb1 (x_r1b 0) capacitor c=10f
Mxo2p x_q2b x_q2 vdg vdg sg13_lv_pmos w=1.0u l=0.13u
Mxo2n x_q2b x_q2 0 0 sg13_lv_nmos w=0.5u l=0.13u
Mxr2ap1 x_r2a_x1 x_q2b vdg vdg sg13_lv_pmos w=2u l=0.13u
Mxr2ap2 x_r2a_a x_clk x_r2a_x1 vdg sg13_lv_pmos w=2u l=0.13u
Mxr2an1 x_r2a_a x_q2b 0 0 sg13_lv_nmos w=1u l=0.13u
Mxr2ap3 x_r2a_b x_clk vdg vdg sg13_lv_pmos w=2u l=0.13u
Mxr2an2 x_r2a_b x_r2a_a x_r2a_x2 0 sg13_lv_nmos w=1u l=0.13u
Mxr2an3 x_r2a_x2 x_clk 0 0 sg13_lv_nmos w=1u l=0.13u
Mxr2ap4 x_r2 x_r2a_b vdg vdg sg13_lv_pmos w=2u l=0.13u
Mxr2an4 x_r2 x_clk x_r2a_x3 0 sg13_lv_nmos w=1u l=0.13u
Mxr2an5 x_r2a_x3 x_r2a_b 0 0 sg13_lv_nmos w=1u l=0.13u

Mxr2bp1 x_r2b_x1 x_q2 vdg vdg sg13_lv_pmos w=2u l=0.13u
Mxr2bp2 x_r2b_a x_clk x_r2b_x1 vdg sg13_lv_pmos w=2u l=0.13u
Mxr2bn1 x_r2b_a x_q2 0 0 sg13_lv_nmos w=1u l=0.13u
Mxr2bp3 x_r2b_b x_clk vdg vdg sg13_lv_pmos w=2u l=0.13u
Mxr2bn2 x_r2b_b x_r2b_a x_r2b_x2 0 sg13_lv_nmos w=1u l=0.13u
Mxr2bn3 x_r2b_x2 x_clk 0 0 sg13_lv_nmos w=1u l=0.13u
Mxr2bp4 x_r2b x_r2b_b vdg vdg sg13_lv_pmos w=2u l=0.13u
Mxr2bn4 x_r2b x_clk x_r2b_x3 0 sg13_lv_nmos w=1u l=0.13u
Mxr2bn5 x_r2b_x3 x_r2b_b 0 0 sg13_lv_nmos w=1u l=0.13u

cr2 (x_r2 0) capacitor c=10f
crb2 (x_r2b 0) capacitor c=10f
Mxo3p x_q3b x_q3 vdg vdg sg13_lv_pmos w=1.0u l=0.13u
Mxo3n x_q3b x_q3 0 0 sg13_lv_nmos w=0.5u l=0.13u
Mxr3ap1 x_r3a_x1 x_q3b vdg vdg sg13_lv_pmos w=2u l=0.13u
Mxr3ap2 x_r3a_a x_clk x_r3a_x1 vdg sg13_lv_pmos w=2u l=0.13u
Mxr3an1 x_r3a_a x_q3b 0 0 sg13_lv_nmos w=1u l=0.13u
Mxr3ap3 x_r3a_b x_clk vdg vdg sg13_lv_pmos w=2u l=0.13u
Mxr3an2 x_r3a_b x_r3a_a x_r3a_x2 0 sg13_lv_nmos w=1u l=0.13u
Mxr3an3 x_r3a_x2 x_clk 0 0 sg13_lv_nmos w=1u l=0.13u
Mxr3ap4 x_r3 x_r3a_b vdg vdg sg13_lv_pmos w=2u l=0.13u
Mxr3an4 x_r3 x_clk x_r3a_x3 0 sg13_lv_nmos w=1u l=0.13u
Mxr3an5 x_r3a_x3 x_r3a_b 0 0 sg13_lv_nmos w=1u l=0.13u

Mxr3bp1 x_r3b_x1 x_q3 vdg vdg sg13_lv_pmos w=2u l=0.13u
Mxr3bp2 x_r3b_a x_clk x_r3b_x1 vdg sg13_lv_pmos w=2u l=0.13u
Mxr3bn1 x_r3b_a x_q3 0 0 sg13_lv_nmos w=1u l=0.13u
Mxr3bp3 x_r3b_b x_clk vdg vdg sg13_lv_pmos w=2u l=0.13u
Mxr3bn2 x_r3b_b x_r3b_a x_r3b_x2 0 sg13_lv_nmos w=1u l=0.13u
Mxr3bn3 x_r3b_x2 x_clk 0 0 sg13_lv_nmos w=1u l=0.13u
Mxr3bp4 x_r3b x_r3b_b vdg vdg sg13_lv_pmos w=2u l=0.13u
Mxr3bn4 x_r3b x_clk x_r3b_x3 0 sg13_lv_nmos w=1u l=0.13u
Mxr3bn5 x_r3b_x3 x_r3b_b 0 0 sg13_lv_nmos w=1u l=0.13u

cr3 (x_r3 0) capacitor c=10f
crb3 (x_r3b 0) capacitor c=10f
Mxo4p x_q4b x_q4 vdg vdg sg13_lv_pmos w=1.0u l=0.13u
Mxo4n x_q4b x_q4 0 0 sg13_lv_nmos w=0.5u l=0.13u
Mxr4ap1 x_r4a_x1 x_q4b vdg vdg sg13_lv_pmos w=2u l=0.13u
Mxr4ap2 x_r4a_a x_clk x_r4a_x1 vdg sg13_lv_pmos w=2u l=0.13u
Mxr4an1 x_r4a_a x_q4b 0 0 sg13_lv_nmos w=1u l=0.13u
Mxr4ap3 x_r4a_b x_clk vdg vdg sg13_lv_pmos w=2u l=0.13u
Mxr4an2 x_r4a_b x_r4a_a x_r4a_x2 0 sg13_lv_nmos w=1u l=0.13u
Mxr4an3 x_r4a_x2 x_clk 0 0 sg13_lv_nmos w=1u l=0.13u
Mxr4ap4 x_r4 x_r4a_b vdg vdg sg13_lv_pmos w=2u l=0.13u
Mxr4an4 x_r4 x_clk x_r4a_x3 0 sg13_lv_nmos w=1u l=0.13u
Mxr4an5 x_r4a_x3 x_r4a_b 0 0 sg13_lv_nmos w=1u l=0.13u

Mxr4bp1 x_r4b_x1 x_q4 vdg vdg sg13_lv_pmos w=2u l=0.13u
Mxr4bp2 x_r4b_a x_clk x_r4b_x1 vdg sg13_lv_pmos w=2u l=0.13u
Mxr4bn1 x_r4b_a x_q4 0 0 sg13_lv_nmos w=1u l=0.13u
Mxr4bp3 x_r4b_b x_clk vdg vdg sg13_lv_pmos w=2u l=0.13u
Mxr4bn2 x_r4b_b x_r4b_a x_r4b_x2 0 sg13_lv_nmos w=1u l=0.13u
Mxr4bn3 x_r4b_x2 x_clk 0 0 sg13_lv_nmos w=1u l=0.13u
Mxr4bp4 x_r4b x_r4b_b vdg vdg sg13_lv_pmos w=2u l=0.13u
Mxr4bn4 x_r4b x_clk x_r4b_x3 0 sg13_lv_nmos w=1u l=0.13u
Mxr4bn5 x_r4b_x3 x_r4b_b 0 0 sg13_lv_nmos w=1u l=0.13u

cr4 (x_r4 0) capacitor c=10f
crb4 (x_r4b 0) capacitor c=10f
Mxf1kq1p x_f1_kq x_q1 vdg vdg sg13_lv_pmos w=0.3u l=0.13u
Mxf1kq1n x_f1_kq x_q1 0 0 sg13_lv_nmos w=0.15u l=0.13u
Mxf1kq2p x_q1 x_f1_kq vdg vdg sg13_lv_pmos w=0.3u l=0.13u
Mxf1kq2n x_q1 x_f1_kq 0 0 sg13_lv_nmos w=0.15u l=0.13u
rkf11 (x_f1_a 0) resistor r=100Meg
rkf12 (x_f1_b 0) resistor r=100Meg
Mxf2kq1p x_f2_kq x_q2 vdg vdg sg13_lv_pmos w=0.3u l=0.13u
Mxf2kq1n x_f2_kq x_q2 0 0 sg13_lv_nmos w=0.15u l=0.13u
Mxf2kq2p x_q2 x_f2_kq vdg vdg sg13_lv_pmos w=0.3u l=0.13u
Mxf2kq2n x_q2 x_f2_kq 0 0 sg13_lv_nmos w=0.15u l=0.13u
rkf21 (x_f2_a 0) resistor r=100Meg
rkf22 (x_f2_b 0) resistor r=100Meg
Mxf3kq1p x_f3_kq x_q3 vdg vdg sg13_lv_pmos w=0.3u l=0.13u
Mxf3kq1n x_f3_kq x_q3 0 0 sg13_lv_nmos w=0.15u l=0.13u
Mxf3kq2p x_q3 x_f3_kq vdg vdg sg13_lv_pmos w=0.3u l=0.13u
Mxf3kq2n x_q3 x_f3_kq 0 0 sg13_lv_nmos w=0.15u l=0.13u
rkf31 (x_f3_a 0) resistor r=100Meg
rkf32 (x_f3_b 0) resistor r=100Meg
Mxf4kq1p x_f4_kq x_q4 vdg vdg sg13_lv_pmos w=0.3u l=0.13u
Mxf4kq1n x_f4_kq x_q4 0 0 sg13_lv_nmos w=0.15u l=0.13u
Mxf4kq2p x_q4 x_f4_kq vdg vdg sg13_lv_pmos w=0.3u l=0.13u
Mxf4kq2n x_q4 x_f4_kq 0 0 sg13_lv_nmos w=0.15u l=0.13u
rkf41 (x_f4_a 0) resistor r=100Meg
rkf42 (x_f4_b 0) resistor r=100Meg
Mxr1akq1p x_r1a_kq x_r1 vdg vdg sg13_lv_pmos w=0.3u l=0.13u
Mxr1akq1n x_r1a_kq x_r1 0 0 sg13_lv_nmos w=0.15u l=0.13u
Mxr1akq2p x_r1 x_r1a_kq vdg vdg sg13_lv_pmos w=0.3u l=0.13u
Mxr1akq2n x_r1 x_r1a_kq 0 0 sg13_lv_nmos w=0.15u l=0.13u
rkr1a1 (x_r1a_a 0) resistor r=100Meg
rkr1a2 (x_r1a_b 0) resistor r=100Meg
Mxr1bkq1p x_r1b_kq x_r1b vdg vdg sg13_lv_pmos w=0.3u l=0.13u
Mxr1bkq1n x_r1b_kq x_r1b 0 0 sg13_lv_nmos w=0.15u l=0.13u
Mxr1bkq2p x_r1b x_r1b_kq vdg vdg sg13_lv_pmos w=0.3u l=0.13u
Mxr1bkq2n x_r1b x_r1b_kq 0 0 sg13_lv_nmos w=0.15u l=0.13u
rkr1b1 (x_r1b_a 0) resistor r=100Meg
rkr1b2 (x_r1b_b 0) resistor r=100Meg
Mxr2akq1p x_r2a_kq x_r2 vdg vdg sg13_lv_pmos w=0.3u l=0.13u
Mxr2akq1n x_r2a_kq x_r2 0 0 sg13_lv_nmos w=0.15u l=0.13u
Mxr2akq2p x_r2 x_r2a_kq vdg vdg sg13_lv_pmos w=0.3u l=0.13u
Mxr2akq2n x_r2 x_r2a_kq 0 0 sg13_lv_nmos w=0.15u l=0.13u
rkr2a1 (x_r2a_a 0) resistor r=100Meg
rkr2a2 (x_r2a_b 0) resistor r=100Meg
Mxr2bkq1p x_r2b_kq x_r2b vdg vdg sg13_lv_pmos w=0.3u l=0.13u
Mxr2bkq1n x_r2b_kq x_r2b 0 0 sg13_lv_nmos w=0.15u l=0.13u
Mxr2bkq2p x_r2b x_r2b_kq vdg vdg sg13_lv_pmos w=0.3u l=0.13u
Mxr2bkq2n x_r2b x_r2b_kq 0 0 sg13_lv_nmos w=0.15u l=0.13u
rkr2b1 (x_r2b_a 0) resistor r=100Meg
rkr2b2 (x_r2b_b 0) resistor r=100Meg
Mxr3akq1p x_r3a_kq x_r3 vdg vdg sg13_lv_pmos w=0.3u l=0.13u
Mxr3akq1n x_r3a_kq x_r3 0 0 sg13_lv_nmos w=0.15u l=0.13u
Mxr3akq2p x_r3 x_r3a_kq vdg vdg sg13_lv_pmos w=0.3u l=0.13u
Mxr3akq2n x_r3 x_r3a_kq 0 0 sg13_lv_nmos w=0.15u l=0.13u
rkr3a1 (x_r3a_a 0) resistor r=100Meg
rkr3a2 (x_r3a_b 0) resistor r=100Meg
Mxr3bkq1p x_r3b_kq x_r3b vdg vdg sg13_lv_pmos w=0.3u l=0.13u
Mxr3bkq1n x_r3b_kq x_r3b 0 0 sg13_lv_nmos w=0.15u l=0.13u
Mxr3bkq2p x_r3b x_r3b_kq vdg vdg sg13_lv_pmos w=0.3u l=0.13u
Mxr3bkq2n x_r3b x_r3b_kq 0 0 sg13_lv_nmos w=0.15u l=0.13u
rkr3b1 (x_r3b_a 0) resistor r=100Meg
rkr3b2 (x_r3b_b 0) resistor r=100Meg
Mxr4akq1p x_r4a_kq x_r4 vdg vdg sg13_lv_pmos w=0.3u l=0.13u
Mxr4akq1n x_r4a_kq x_r4 0 0 sg13_lv_nmos w=0.15u l=0.13u
Mxr4akq2p x_r4 x_r4a_kq vdg vdg sg13_lv_pmos w=0.3u l=0.13u
Mxr4akq2n x_r4 x_r4a_kq 0 0 sg13_lv_nmos w=0.15u l=0.13u
rkr4a1 (x_r4a_a 0) resistor r=100Meg
rkr4a2 (x_r4a_b 0) resistor r=100Meg
Mxr4bkq1p x_r4b_kq x_r4b vdg vdg sg13_lv_pmos w=0.3u l=0.13u
Mxr4bkq1n x_r4b_kq x_r4b 0 0 sg13_lv_nmos w=0.15u l=0.13u
Mxr4bkq2p x_r4b x_r4b_kq vdg vdg sg13_lv_pmos w=0.3u l=0.13u
Mxr4bkq2n x_r4b x_r4b_kq 0 0 sg13_lv_nmos w=0.15u l=0.13u
rkr4b1 (x_r4b_a 0) resistor r=100Meg
rkr4b2 (x_r4b_b 0) resistor r=100Meg
.ends

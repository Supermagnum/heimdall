* P2.7.4b lo_inv_1_2 LVS reference [SCH]
.subckt lo_inv_1_2 a y vdd gnd
Mxp y a vdd vdd sg13_lv_pmos w=2u l=0.13u
Mxn y a 0 0 sg13_lv_nmos w=1u l=0.13u
.ends

* P2.7.4b lo_inv_9_18 LVS reference — 2× parallel 4.5/9 [SCH]
.subckt lo_inv_9_18 a y vdd gnd
Mxp y a vdd vdd sg13_lv_pmos w=9u l=0.13u m=2
Mxn y a 0 0 sg13_lv_nmos w=4.5u l=0.13u m=2
.ends

* Extracted by KLayout with SG13G2 LVS runset on : 17/11/2026 18:51

.SUBCKT bias_r gnd vgn vgp vvb
R$1 vvb vgp gnd rhigh w=0.5u l=42.095u ps=0.18u b=16 m=1
R$2 vvb vgn gnd rhigh w=0.5u l=42.095u ps=0.18u b=16 m=1
.ENDS bias_r

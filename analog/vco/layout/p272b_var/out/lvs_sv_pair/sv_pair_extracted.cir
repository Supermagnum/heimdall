* Extracted by KLayout with SG13G2 LVS runset on : 17/11/2026 18:49

.SUBCKT sv_pair G1 G2 W
C$1 G1 W G2 \$1 sg13_hv_svaricap w=3.74u l=0.3u Nx=10
C$2 G1 W G2 \$1 sg13_hv_svaricap w=3.74u l=0.3u Nx=10
.ENDS sv_pair
